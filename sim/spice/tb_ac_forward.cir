* rev B multicoupler
.include models_bjt.lib

CIN1 IN XIN1 4.7e-06
RIN1 XIN1 XIN2 0.02
LIN1 XIN2 N1 8n
RBL N1 0 10000.0
DA1 N1 DA D1N4148
DA2 DA 0 D1N4148
DB1 0 DB D1N4148
DB2 DB N1 D1N4148
CF1 N1 0 4.3e-11
LF1 N1 NL1 2.2e-07
RLF1 NL1 N2 1.0367255756846316
CF2 N2 0 1e-10
LF2 N2 NL2 2.7e-07
RLF2 NL2 N3 1.2723450247038663
CF3 N3 0 1e-10
LF3 N3 NL3 2.2e-07
RLF3 NL3 N4 1.0367255756846316
CF4 N4 0 4.3e-11
CPN4 N4 0 1p
CBN1 N4 XNB 2.2e-06
RBNE XNB YNB 0.02
LBNE YNB BN 6n
CBP1 N4 XPB 2.2e-06
RBPE XPB YPB 0.02
LBPE YPB BP 6n
Q1N X BN EN1 2N3904
LEN EN1 EN 5n
RE1 EN 0 56
Q1P X BP EP1 2N3906
LEP EP1 EP 5n
RE2 VCC EP 56
R1A X RM 1500.0
R1B RM BN 1500.0
CRM RM 0 10u
R2 BN 0 3300.0
R3A X RMP 1500.0
R3B RMP BP 1500.0
CRMP VCC RMP 10u
R4 BP VCC 3300.0
CLX X LX 2.2e-06
RLX LX 0 220
RF X FB 220
CFB1 FB FB2 2.2e-06
LFB FB2 N4 6n
CPX X 0 2p
Q2A 0 X E2A 2N3906
RX1 E2A D1 15
RPU VCC D1 360
Q3A VCC X E3A 2N3904
RX2 D2 E3A 15
RPD D2 0 360
RCOL VCC VCF 4.7
CCOL VCF 0 100n
Q2 VCF D1 EF1 2N3904
LEF EF1 EF 5n
REO1 EF OUT 3.3
Q3 0 D2 EG1 2N3906
LEG EG1 EG 5n
REO2 EG OUT 3.3
CPOUT OUT 0 3p
CPD1 D1 0 1p
CPD2 D2 0 1p
CO1A OUT XO1 4.7e-06
RO1E XO1 YO1 0.02
LO1E YO1 ZO1 8n
RS1 ZO1 SO1 51
LS1 SO1 P1 8n
CPP1 P1 0 2p
CO2A OUT XO2 4.7e-06
RO2E XO2 YO2 0.02
LO2E YO2 ZO2 8n
RS2 ZO2 SO2 51
LS2 SO2 P2 8n
CPP2 P2 0 2p
CO3A OUT XO3 4.7e-06
RO3E XO3 YO3 0.02
LO3E YO3 ZO3 8n
RS3 ZO3 SO3 51
LS3 SO3 P3 8n
CPP3 P3 0 2p
CO4A OUT XO4 4.7e-06
RO4E XO4 YO4 0.02
LO4E YO4 ZO4 8n
RS4 ZO4 SO4 51
LS4 SO4 P4 8n
CPP4 P4 0 2p
VCC VCC 0 9.9
VGIN GIN 0 dc 0 ac 2
RGIN GIN IN 50
RL1 P1 0 50
RL2 P2 0 50
RL3 P3 0 50
RL4 P4 0 50

.options temp=27 tnom=27
.control
ac dec 40 1k 200meg
* source EMF = 2 V, so v(p1) is the transducer voltage gain and v(in)-1 is S11
let s21db=db(v(p1))
let s11db=db(v(in)-1)
wrdata ac_forward.txt s21db s11db
plot s21db s11db xlog
.endc
.end
