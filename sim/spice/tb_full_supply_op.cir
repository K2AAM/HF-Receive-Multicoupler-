* Generated by sim/scripts/export_netlists.py from gen.params('A') - build A: RE1=56, RE2=56, RF=220, RLX=220
* Run: cd sim/spice && ngspice -b tb_full_supply_op.cir
* HF multicoupler rev B
.include models_bjt.lib

CIN1 IN XIN1 4.7e-06
RIN1 XIN1 XIN2 0.02
LIN1 XIN2 N1 8n
RBL N1 0 10000.0
DA1 N1 DA D1N4148
DA2 DA 0 D1N4148
DB1 0 DB D1N4148
DB2 DB N1 D1N4148
CF1 N1 0 4.3e-11
LF1 N1 NL1 2.2e-07
RLF1 NL1 N2 1.0367255756846316
CF2 N2 0 1e-10
LF2 N2 NL2 2.7e-07
RLF2 NL2 N3 1.2723450247038663
CF3 N3 0 1e-10
LF3 N3 NL3 2.2e-07
RLF3 NL3 N4 1.0367255756846316
CF4 N4 0 4.3e-11
CPN4 N4 0 1p
CBN N4 XNB 2.2e-06
RBNE XNB YNB 0.02
LBNE YNB BN 6n
CBP N4 XPB 2.2e-06
RBPE XPB YPB 0.02
LBPE YPB BP 6n
Q1N X BN EN1 2N3904
LEN EN1 EN 5n
RE1 EN 0 56
Q1P X BP EP1 2N3906
LEP EP1 EP 5n
RE2 VCC EP 56
R1A X RM 1500.0
R1B RM BN 1500.0
CRM RM 0 1e-05
R2 BN 0 3300.0
R3A X RMP 1500.0
R3B RMP BP 1500.0
CRMP VCC RMP 1e-05
R4 BP VCC 3300.0
CLX X LX 2.2e-06
RLX LX 0 220
RF X FB 220
CFB FB FB2 2.2e-06
LFB FB2 N4 6n
CPX X 0 2p
Q2A 0 X E2A 2N3906
RX1 E2A D1 15
RPU VCC D1 360
Q3A VCC X E3A 2N3904
RX2 D2 E3A 15
RPD D2 0 360
RCOL VCC VCF 4.7
CCOL VCF 0 100n
Q2 VCF D1 EF1 2N3904
LEF EF1 EF 5n
REO1 EF OUT 3.3
Q3 0 D2 EG1 2N3906
LEG EG1 EG 5n
REO2 EG OUT 3.3
CPOUT OUT 0 3p
CPD1 D1 0 1p
CPD2 D2 0 1p
CO1 OUT XO1 4.7e-06
RO1E XO1 YO1 0.02
LO1E YO1 ZO1 8n
RS1 ZO1 SO1 51
LS1 SO1 P1 8n
CPP1 P1 0 2p
CO2 OUT XO2 4.7e-06
RO2E XO2 YO2 0.02
LO2E YO2 ZO2 8n
RS2 ZO2 SO2 51
LS2 SO2 P2 8n
CPP2 P2 0 2p
CO3 OUT XO3 4.7e-06
RO3E XO3 YO3 0.02
LO3E YO3 ZO3 8n
RS3 ZO3 SO3 51
LS3 SO3 P3 8n
CPP3 P3 0 2p
CO4 OUT XO4 4.7e-06
RO4E XO4 YO4 0.02
LO4E YO4 ZO4 8n
RS4 ZO4 SO4 51
LS4 SO4 P4 8n
CPP4 P4 0 2p
* ---- supply ----
VIN J6 0 dc 13.8 PWL(0 0 0.001 13.8)
RSRC J6 J6A 0.05
RPTC J6A J6B 1.33
D5 J6B UIN D1N5819
C20 UIN C20E 0.00022
R20E C20E 0 0.15
C20B UIN 0 100n
BUT UTGT 0 V = min(v(UADJ)+1.25, v(UIN)-1.7)
BPASS UIN UPI I = min(1.5, max(0, (v(UTGT)-v(UPI))*50))
VRIP UPI UPJ dc 0 ac 0
RZU UPJ UPK 0.005
LZU UPK UOUT 3e-08
CPI UPI 0 1n
IADJ UOUT UADJ 5e-05
D6 UOUT UIN D1N4002
D7 UADJ UOUT D1N4002
R10 UOUT UADJ 240
R11 UADJ 0 1650.0
C21 UADJ 0 1e-05
CU1O UOUT CU1E 1e-05
RU1E CU1E 0 0.5
L4 UOUT L4A 1e-05
RL4DCR L4A L4B 0.048
RDMP L4B VCC 1.0
C22 VCC C22E 0.00047
R22E C22E 0 0.1
C22B VCC 0 100n
.model D1N5819 D(IS=31.7u RS=0.051 N=1.373 CJO=110p M=0.35 BV=40)
.model D1N4002 D(IS=14.1n RS=33.9m N=1.984 CJO=51.2p M=0.3 BV=100)

RGIN IN 0 50
RL1 P1 0 50
RL2 P2 0 50
RL3 P3 0 50
RL4 P4 0 50

.options temp=27 tnom=27
.control
op
print v(vcc) v(uout) v(uin) i(vin)
echo @@SIM_COMPLETE@@
.endc
.end
